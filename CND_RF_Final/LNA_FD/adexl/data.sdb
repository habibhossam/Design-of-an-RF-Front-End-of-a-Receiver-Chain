ADE simulation setup
Run mode: Single Run, Sweeps and Corners
Tests:
  CND_RF_Final:LNA_FD:1: CND_RF_Final/LNA_FD/schematic, simulator spectre
Global variables:
  Pin = 0
