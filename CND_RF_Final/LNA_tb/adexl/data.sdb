ADE simulation setup
Run mode: Single Run, Sweeps and Corners
Tests:
  CND_RF_Final:LNA_tb:1: CND_RF_Final/LNA_tb/schematic, simulator spectre
Global variables:
  Pin = 0
