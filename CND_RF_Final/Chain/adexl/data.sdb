ADE simulation setup
Run mode: Single Run, Sweeps and Corners
Tests:
  CND_RF_Final:Chain:1: CND_RF_Final/Chain/schematic, simulator spectre
Global variables:
  LO = 300m
  Pin = 0
