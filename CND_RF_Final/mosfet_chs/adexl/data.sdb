ADE simulation setup
Run mode: Single Run, Sweeps and Corners
Tests:
  CND_RF_Final:mosfet_chs:1: CND_RF_Final/mosfet_chs/schematic, simulator spectre
Global variables:
  vgs = 550m
  W = 5u
